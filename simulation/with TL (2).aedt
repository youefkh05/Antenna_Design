# Ansys Electronics Desktop project, version 2019.3
materials:
  vacuum: permittivity=1
  Rogers RT/duroid 5880 (tm): permittivity=2.2 dielectric_loss_tangent=0.0009
  pec: conductivity=1e+30
  Rogers RO4003 (tm): permittivity=3.55 dielectric_loss_tangent=0.0027

design HFSSDesign1 (HFSS, DrivenModal, model units mm)
variables:
  Lp = 4.1mm  # optimise 1.961496581mm..5.884489743mm
  Wp = 4.97mm  # optimise 2.538622579mm..7.615867737mm
  hs = 0.406mm
  Ws = Wp+6*hs+2.271131283mm+2.271131283mm
  Ls = 6*hs+Lp*2+4.21mm
  xsub = -Ls/2
  ysub = -Ws/2
  xfeed = 1.2mm  # optimise 0.4620027115mm..1.3860081345mm
  dp = 0.343834434mm  # optimise 0.19101913mm..0.57305739mm
  rcoax = 0.16mm
  hcoax = 0.5mm
  rprope = 0.07mm
  Lair = 0.01+Ls
  Wair = 0.01+Ws
  xair = Lair/2
  yair = Wair/2
  hair = 5mm
  yfeed = 0mm
  xp = dp/2
  yp = -Wp/2
  Wp2 = 12*hs+4.7*2
  hgnd = -0.032mm
  X_TL_1 = 2.288307mm
  Y_TL_1 = 0.276146mm
  Y_TL_vertical = 3.105225mm
geometry:
  Sub1 [Rogers RO4003 (tm)] = box(corner=(xsub, ysub, 0mm), size=(Ls, Ws, hs))
  Patch [Rogers RT/duroid 5880 (tm)] = rectangle(corner=(xp, yp, hs), x_size=Lp, y_size=Wp)
  Coax [vacuum] = cylinder(axis=Z, base_centre=(xp+xfeed, yfeed, 0mm), radius=rcoax, height=-hcoax)
  Coax_Pin [pec] = cylinder(axis=Z, base_centre=(xp+xfeed, yfeed, 0mm), radius=rprope, height=-hcoax)
  Prope [pec] = cylinder(axis=Z, base_centre=(xp+xfeed, yfeed, 0mm), radius=rprope, height=hs)
  Air [vacuum] = box(corner=(-xair, -yair, 0), size=(Lair, Wair, hair))
  Patch2 = rectangle(corner=(xp-Lp-dp, yp, hs), x_size=Lp, y_size=Wp)
  Coax2 [vacuum] = cylinder(axis=Z, base_centre=(-(xp+xfeed), yfeed, 0mm), radius=rcoax, height=-hcoax)
  Coax_Pin2 [pec] = cylinder(axis=Z, base_centre=(-(xp+xfeed), yfeed, 0mm), radius=rprope, height=-hcoax)
  Prope2 [pec] = cylinder(axis=Z, base_centre=(-(xp+xfeed), yfeed, 0mm), radius=rprope, height=hs)
  inf_GND [pec] = box(corner=(xsub, ysub, 0mm), size=(Ls, Ws, hgnd))
  Cylinder_cut_2 = cylinder(axis=Z, base_centre=(-(xp+xfeed), yfeed, 0), radius=rcoax, height=hgnd)
  Cylinder_cut_1 = cylinder(axis=Z, base_centre=(xp+xfeed, yfeed, 0), radius=rcoax, height=hgnd)
  inf_GND.subtract(Cylinder_cut_1)
  inf_GND.subtract(Cylinder_cut_2)
  Sub_TL [Rogers RO4003 (tm)] = box(corner=(xsub, ysub, 0mm), size=(Ls, Ws, -hcoax))
  TL1 = rectangle(corner=(-3.23mm, -0.14mm, -0.203mm), x_size=X_TL_1, y_size=Y_TL_1)
  TL2 [pec] = rectangle(corner=((-3.26+4.2) mm, -0.14mm, -0.203mm), x_size=X_TL_1, y_size=Y_TL_1)
  vertical_R = rectangle(corner=(0.94mm, -0.14mm, -0.203mm), x_size=0.276146mm, y_size=Y_TL_vertical)
  vertiacal_L = rectangle(corner=(-0.941693mm, -0.14mm, -0.203mm), x_size=0.276146mm, y_size=Y_TL_vertical)
  vertiacal_L.move(-0.8mm, 0mm, 0mm)
  vertiacal_L.move(0.52mm, 0mm, 0mm)
  tL_horizontal = rectangle(corner=(-1.221693mm, 2.965225mm, -0.203mm), x_size=2.437693mm, y_size=0.276146mm)
  tL_horizontal.move(0mm, -0.6mm, 0mm)
  tL_horizontal.move(0mm, 0.325mm, 0mm)
  TL1.unite(vertiacal_L)
  TL2.unite(vertical_R)
  TL2.unite(tL_horizontal)
  TL2.unite(TL1)
  T_feed = rectangle(corner=(-(0.45407/2) mm, 0mm, -0.203mm), x_size=0.45407mm, y_size=4.494783mm)
  T_feed.move(0mm, 2.6mm, 0mm)
  T_feed.move(0mm, 0.15mm, 0mm)
  T_feed.move(0mm, -0.05mm, 0mm)
  TL2.unite(T_feed)
  TL2.move(-10mm, 0mm, 0mm)
  TL2.move(-7mm, 0mm, 1mm)
  Sub_TL.move(0mm, 0mm, 0mm)
  over4_1 = box(corner=(-(xp+xfeed)-2*rcoax, -rcoax, -hcoax), size=(0.839559mm, 2.271486 mm+2*rcoax, -0.03mm))
  0ver4_2 = box(corner=((xp+xfeed) -2*rcoax, -rcoax, -hcoax), size=(0.839559mm, 2.271486  mm+2*rcoax, -0.03mm))
  over2_2 = box(corner=((xp+xfeed) -2*rcoax, -rcoax+2.271486 mm+2*rcoax, -hcoax), size=(1.118398mm, 3.542645283mm, -0.03mm))
  over2_1 [pec] = box(corner=(-(xp+xfeed)-2*rcoax-0.278839mm, -rcoax+2.271486 mm+2*rcoax, -hcoax), size=(1.118398mm, 3.542645283mm, -0.03mm))
  Box5 = box(corner=(-0.852358217mm, (5.974131283-1.118398) mm, -hcoax), size=(1.904275434mm, 1.118398mm, -0.03mm))
  Rectangle1 = rectangle(corner=(-0.852358217mm, 5.974131283mm, -0.53mm), z_size=(0.03+0.5) mm, x_size=1.904275434mm)
  over2_1.unite(over2_2, Box5, 0ver4_2, over4_1)
  group Input_feed1 = Coax, Coax_Pin, Prope
  group Input_feed2 = Coax2, Coax_Pin2, Prope2
boundaries and excitations:
  PerfE_Patch: Perfect E Objects=Patch
  Rad1: Radiation Faces=Air.face(+x, +y, -y, -x, +z)
  PerfE1: Perfect E Objects=Patch2
  PerfE_TL: Perfect E Objects=TL2
  1: Lumped Port Objects=Rectangle1 Modes{Mode1{IntLine{middle of Rectangle1.edge(z at corner) -> Rectangle1.edge(z opposite corner) at 0.553 along} CharImp=Zpi RenormImp=50ohm}} Impedance=50ohm
  reference conductors: inf_GND
setups:
  Setup1: HfssDriven Frequency=20GHz MaxDeltaS=0.02 MaximumPasses=18 MinimumPasses=1 MinimumConvergedPasses=1 PercentRefinement=30 BasisOrder=1 PortAccuracy=2
    sweep Sweep: 18GHz to 25GHz step 0.1GHz; Type=Fast SaveFields SaveRadFields GenerateFieldsForAllFreqs
source amplitudes:
  1:1: 1W 0deg
optimetrics:
  OptimizationSetup1: Optimization Optimizer="Quasi Newton" AnalysisStopOptions{StopForNumIteration MaxNumIteration=1000 MinNumIteration=10} CostFuncNormType=L2 Acceptable_Cost=0 Noise=0.0001 UpdateDesignWhenDone
    vary Lp: Min=1.961496581mm Max=5.884489743mm MinStep=0.039229932mm MaxStep=0.39229932mm MinFocus=1.961496581mm MaxFocus=5.884489743mm start=4mm
    vary xfeed: Min=0.46200271mm Max=1.3860081mm MinStep=0.0092400542mm MaxStep=0.092400542mm MinFocus=0.46200271mm MaxFocus=1.3860081mm start=0.915806943mm
    goal dB(S(1,1)) <= -15 weight 5 on Setup1 : Sweep at Freq 20GHz
    goal mag(Z(1,1)) >= 20 weight 1 on Setup1 : Sweep at Freq 20GHz
    goal mag(Z(1,1)) >= 50 weight 1 on Setup1 : Sweep at Freq 20GHz
radiation setups:
  e_plane: Infinite Sphere Theta=-180deg..180deg step 2deg Phi=0deg..0deg step 1deg
  h_plane: Infinite Sphere Theta=-180deg..180deg step 2deg Phi=90deg..90deg step 1deg
  3d: Infinite Sphere Theta=-180deg..180deg step 2deg Phi=0deg..360deg step 2deg
reports:
  Eradation_pattern: abs(rETotal) vs Theta on Setup1 : LastAdaptive, e_plane [Phi=all Freq=20GHz]
  Hradation_pattern: abs(rETotal) vs Theta on Setup1 : LastAdaptive, h_plane [Phi=all Freq=20GHz]
  Co_X_graph: dB10normalize(GainPhi), dB10normalize(GainTheta) vs Theta on Setup1 : LastAdaptive, e_plane [Phi=0deg Freq=20GHz]
  Gain Plot 1: GainTotal vs Theta on Setup1 : LastAdaptive, e_plane [Phi=all Freq=20GHz dp=all]
  Port Zo Plot 1: mag(Zo(1)) vs Freq on Setup1 : Sweep; markers MX1 at x=2.0233247e+10
  VSWR Plot 1: VSWR(1) vs Freq on Setup1 : Sweep; markers m1 at 20GHz
  Gain Plot 2: mag(GainTotal) vs Phi, Theta on Setup1 : LastAdaptive, 3d [Freq=20GHz]
  S Parameter Plot 1: dB(S(1,1)) vs Freq on Setup1 : Sweep; markers m1 at 20GHz, MY1 at y=-10.0499
  Z Parameter Plot 1: mag(Z(1,1)) vs Freq on Setup1 : Sweep; markers MX1 at x=2.0003421e+10
  Z Parameter Plot 2: mag(Z(2,2)) vs Freq on Setup1 : Sweep; markers MX1 at x=2.0003421e+10
